* NekoSpice v0.1 example: half-wave diode rectifier
Vin in 0 SIN(0 10 1k)
D1 in out D4148
Rload out 0 1k
.model D4148 D(Is=2.52n Rs=0.568 N=1.906 Cjo=1p M=0.03 Eg=1.11)
.tran 10u 5m
.control
run
.endc
.end
